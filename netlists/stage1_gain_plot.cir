* Stage 1: AC gain - Bode plot
.lib /home/sai/opamp_project/models/sky130_fd_pr/models/sky130.lib.spice tt

VDD vdd 0 1.8
VSS vss 0 0
VIP  inp  0 DC 0.9 AC 0.5
VIN  inn  0 DC 0.9 AC -0.5
VBIAS nbias 0 DC 0.89

XM1 d1 inp  tail vss sky130_fd_pr__nfet_01v8 L=0.2 W=2
XM2 d2 inn  tail vss sky130_fd_pr__nfet_01v8 L=0.2 W=2
XM3 d1 d1 vdd vdd sky130_fd_pr__pfet_01v8 L=0.2 W=5
XM4 d2 d1 vdd vdd sky130_fd_pr__pfet_01v8 L=0.2 W=5
XM5 tail nbias vss vss sky130_fd_pr__nfet_01v8 L=0.5 W=4

.ac dec 10 1 1G

.control
run
plot vdb(d2)
.endc

.end
