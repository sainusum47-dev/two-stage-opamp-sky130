* Transient step response - Closed-loop unity-gain buffer with nodeset
.lib /home/sai/opamp_project/models/sky130_fd_pr/models/sky130.lib.spice tt

VDD vdd 0 1.8
VSS vss 0 0

VIP  inp  0 PULSE(0.8 1.0 1u 10n 10n 15u 30u)
VBIAS  nbias  0 DC 0.89
VBIAS2 nbias2 0 DC 0.401

XM1 d1 inp  tail vss sky130_fd_pr__nfet_01v8 L=0.2 W=2
XM2 d2 vout tail vss sky130_fd_pr__nfet_01v8 L=0.2 W=2
XM3 d1 d1 vdd vdd sky130_fd_pr__pfet_01v8 L=0.2 W=5
XM4 d2 d1 vdd vdd sky130_fd_pr__pfet_01v8 L=0.2 W=5
XM5 tail nbias vss vss sky130_fd_pr__nfet_01v8 L=0.5 W=4

XM6 vout d2 vss vss sky130_fd_pr__nfet_01v8 L=2.0 W=6
XM7 vout nbias2 vdd vdd sky130_fd_pr__pfet_01v8 L=2.0 W=12

Cc  d2  comp_mid  4p
Rz  comp_mid  vout  5k
CL  vout  0  2p

.nodeset v(vout)=0.9 v(d1)=0.82 v(d2)=0.82 v(tail)=0.1

.tran 0.05u 60u

.control
run
plot v(inp) v(vout)
.endc

.end
